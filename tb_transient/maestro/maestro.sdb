ADE simulation setup
Run mode: Single Run, Sweeps and Corners
Tests:
  our_opamp_tb_transient_1: our_opamp/tb_transient/schematic, simulator spectre
    Variables: Cc = 0.5p; L12 = 1.6u; L34 = 1.6u; L7 = 1.6u; R = 4k; W12 = L12*1.89; W34 = 6.42*L34; W6 = 64.2u; W7 = 33.06*L7; VB = 0.7
