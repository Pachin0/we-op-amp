ADE simulation setup
Test our_opamp_tb_transient_1: our_opamp/tb_transient/schematic, simulator spectre
  Models: /nethome/srahman315/analog-design/PDK/sky130_release_0.0.9/libs/sky130_fd_pr_main/../../models/sky130.lib.spice[tt]
  Variables: L12 = 1.6u; R = 4k; Cc = 0.5p; W6 = 64.2u; L7 = 1.6u; L34 = 1.6u; VB = 0.7; W34 = 6.42*L34; W7 = 33.06*L7; W12 = L12*1.89
  Temperature: 27
  Analysis tran: stop=2u maxstep=0.5n
  Output v /net6; tran (V) = vtime('tran "/net6")
  Output v /net3; tran (V) = vtime('tran "/net3")
  Output ymax(deriv(VT("/net3")))
  Output ymin(deriv(VT("/net3")))
  Output settlingTime(VT("/net3") 9e-08 t 9e-07 t 1 nil "time")
  Signals: /net3
Run mode: Single Run, Sweeps and Corners
