ADE simulation setup
Test our_opamp_tb_dc_sweep_1: our_opamp/tb_dc_sweep/schematic, simulator spectre
  Models: /nethome/srahman315/analog-design/PDK/sky130_release_0.0.9/libs/sky130_fd_pr_main/../../models/sky130.lib.spice[tt]
  Variables: W5 = 6.61u; VIN = 0.9; L12 = 1.6u; R = 4k; Cc = 0.5p; W6 = 64.2u; L7 = 1.6u; L34 = 1.6u; VB = 0.7; W34 = 6.42*L34; W7 = 33.06*L7; W12 = L12*1.89
  Temperature: 27
  Operating points saved: /I0/NM2 (vds vdsat); /I0/NM0 (vdsat vds); /I0/NM1 (vdsat vds)
  Analysis dc: sweep VIN start=0.4 stop=1.6 step=0.01
  Output (VDC("/net3") - VDC("/net6"))
  Output deriv(VDC("/net3"))
  Output cross(deriv(VDC("/net3")) 0.95 1 "falling" nil nil nil)
  Output cross(deriv(VDC("/net3")) 1.05 1 "falling" nil nil nil)
  Output (value(VDC("/net3") 1.61217) - value(VDC("/net3") 0.207511))
  Output (OS("/I0/NM2" "vds") - OS("/I0/NM2" "vdsat"))
  Output cross((OS("/I0/NM2" "vds") - OS("/I0/NM2" "vdsat")) 0 1 "rising" nil nil nil)
  Output (OS("/I0/NM0" "vds") - OS("/I0/NM0" "vdsat"))
  Output (OS("/I0/NM1" "vds") - OS("/I0/NM1" "vdsat"))
  Output VDC("/net6")
  Output VDC("/net3")
  Output ymin(deriv(VDC("/net3")))
  Output ymax(deriv(VDC("/net3")))
  Signals: /net3, /net6
Run mode: Single Run, Sweeps and Corners
