ADE simulation setup
Run mode: Single Run, Sweeps and Corners
Tests:
  our_opamp_testbench1_1: our_opamp/testbench1/schematic, simulator spectre
    Variables: VB = 0.7; W34 = 6.42*L34; L34 = 1.6u; W7 = 33.06*L7; L7 = 1.6u; W6 = 64.2u; Cc = 0.5p; R = 4k; W12 = L12*1.89; L12 = 1.6u; W5 = 6.61u; VCM = 0.9
    Outputs: OP("/I0/NM0" "gm")
