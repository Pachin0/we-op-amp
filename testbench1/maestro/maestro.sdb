ADE simulation setup
Run mode: Single Run, Sweeps and Corners
Tests:
  our_opamp_testbench1_1: our_opamp/testbench1/schematic, simulator spectre
    Variables: VB = 0.65
    Outputs: OP("/I0/NM0" "gm")
