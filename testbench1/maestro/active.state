ADE simulation setup
Test our_opamp_testbench1_1: our_opamp/testbench1/schematic, simulator spectre
  Models: /nethome/srahman315/analog-design/PDK/sky130_release_0.0.9/models/sky130.lib.spice[tt]
  Variables: VCM = 0.9; W5 = 6.61u; L12 = 1.6u; R = 4k; Cc = 0.5p; W6 = 64.2u; L7 = 1.6u; L34 = 1.6u; VB = 0.7; W34 = 6.42*L34; W7 = 33.06*L7; W12 = L12*1.89
  Temperature: 27
  Analysis dc: (saves the operating point)
  Analysis stb: start=1 stop=1G dec=20 stbProbeMode=single-ended
  Output OP("/I0/NM0" "gm")
  Output loopGain Phase = phaseDegUnwrapped(getData("loopGain" ?result "stb"))
  Output loopGain dB20 = db(mag(getData("loopGain" ?result "stb")))
  Output OP("/I0/PM2" "gm")
  Output Phase Margin = getData("phaseMargin" ?result "stb_margin")
  Output OP("/I0/NM3" "gds")
  Output OP("/I0/PM2" "gds")
  Output OP("/I0/PM1" "gds")
  Output OP("/I0/NM1" "gds")
  Output getData("phaseMarginFreq" ?result "stb_margin")
  Output (1.8 * abs(IDC("/V0/PLUS")))
  Signals: /I0/NM2/S (terminal) as tailcurrent, /net3 as outputvoltage, /V0/PLUS (terminal)
Run mode: Single Run, Sweeps and Corners
Setup values for test our_opamp_testbench1_1: L34 = 1.2u; W6 = 95u; Cc = 0.35p:0.05p:0.6p
