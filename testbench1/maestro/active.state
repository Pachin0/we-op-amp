ADE simulation setup
Test our_opamp_testbench1_1: our_opamp/testbench1/schematic, simulator spectre
  Models: /nethome/jmartinez342/we-op-amp/analog-design/PDK/sky130_release_0.0.9/libs/sky130_fd_pr_main/../../models/sky130.lib.spice[tt]
  Variables: VB = 0.65
  Temperature: 27
  Analysis stb: start=1 stop=1G dec=20 stbProbeMode=single-ended
  Output OP("/I0/NM0" "gm")
  Output loopGain Phase = phaseDegUnwrapped(getData("loopGain" ?result "stb"))
  Output loopGain dB20 = db(mag(getData("loopGain" ?result "stb")))
  Signals: /I0/NM2/S (terminal) as tailcurrent, /net3 as outputvoltage
Run mode: Single Run, Sweeps and Corners
Setup values for test our_opamp_testbench1_1: VB = 0.7; W34 = 6.42*L34; L34 = 1.2u; W7 = 33.06*L7; L7 = 1.6u; W6 = 95u; Cc = 0.35p:0.05p:0.6p
